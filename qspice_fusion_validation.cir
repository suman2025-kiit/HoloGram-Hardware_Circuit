* QSPICE Circuit-Level Fusion Validation
* HoloGram Circuit Simulation - Fusion using AND Gate

V1 DepthVoltage in1 0 PULSE(0 5 0 1n 1n 10n 20n)
V2 PoseVoltage in2 0 PULSE(0 5 5n 1n 1n 10n 20n)

* AND gate using NAND followed by NOT (NAND + Inverter)
* NAND Gate
M1 out nand_in in2 Vdd Vdd PMOS
M2 out nand_in in2 Vdd Vdd PMOS
M3 nand_in in1 0 0 NMOS
M4 nand_in in2 0 0 NMOS

* Inverter
M5 fusion_out nand_in Vdd Vdd PMOS
M6 fusion_out nand_in 0 0 NMOS

* Power Supply
Vdd Vdd 0 DC 5

* Load
Rload fusion_out 0 1k

* Analysis
.tran 0.1n 100n
.control
run
plot V(in1) V(in2) V(fusion_out)
.endc

.end
